.title KiCad schematic
U3 sys_transfer_req Net-_U102-Pad3_ adc_bridge_1
U5 GND Net-_U102-Pad5_ adc_bridge_1
U2 PRESETn Net-_U102-Pad2_ adc_bridge_1
U4 sys_write_req Net-_U102-Pad4_ adc_bridge_1
U1 PCLK Net-_U1-Pad2_ adc_bridge_1
U7 GND Net-_U102-Pad7_ adc_bridge_1
U6 GND Net-_U102-Pad6_ adc_bridge_1
U8 GND Net-_U102-Pad8_ adc_bridge_1
U9 GND Net-_U102-Pad9_ adc_bridge_1
U10 GND Net-_U10-Pad2_ adc_bridge_1
v3 sys_write_req GND pulse
v2 sys_transfer_req GND pulse
U205 sys_transfer_req plot_v1
U206 sys_write_req plot_v1
v1 PRESETn GND pulse
v4 PCLK GND pulse
U203 PCLK plot_v1
U204 PRESETn plot_v1
U12 GND Net-_U102-Pad12_ adc_bridge_1
U13 GND Net-_U102-Pad13_ adc_bridge_1
U11 GND Net-_U102-Pad11_ adc_bridge_1
U14 GND Net-_U102-Pad14_ adc_bridge_1
U15 GND Net-_U102-Pad15_ adc_bridge_1
U16 GND Net-_U102-Pad16_ adc_bridge_1
U19 GND Net-_U102-Pad19_ adc_bridge_1
U22 GND Net-_U102-Pad22_ adc_bridge_1
U18 GND Net-_U102-Pad18_ adc_bridge_1
U17 GND Net-_U102-Pad17_ adc_bridge_1
U21 GND Net-_U102-Pad21_ adc_bridge_1
U20 GND Net-_U102-Pad20_ adc_bridge_1
U89 GND Net-_U102-Pad89_ adc_bridge_1
U92 GND Net-_U102-Pad92_ adc_bridge_1
U93 GND Net-_U102-Pad93_ adc_bridge_1
U90 GND Net-_U102-Pad90_ adc_bridge_1
U91 GND Net-_U102-Pad91_ adc_bridge_1
U94 GND Net-_U102-Pad94_ adc_bridge_1
U95 GND Net-_U102-Pad95_ adc_bridge_1
U86 GND Net-_U102-Pad86_ adc_bridge_1
U87 GND Net-_U102-Pad87_ adc_bridge_1
U85 GND Net-_U102-Pad85_ adc_bridge_1
U84 GND Net-_U102-Pad84_ adc_bridge_1
U88 GND Net-_U102-Pad88_ adc_bridge_1
U99 GND Net-_U102-Pad99_ adc_bridge_1
U100 GND Net-_U100-Pad2_ adc_bridge_1
U96 GND Net-_U102-Pad96_ adc_bridge_1
U101 Net-_I2-Pad1_ Net-_U101-Pad2_ adc_bridge_1
U97 GND Net-_U102-Pad97_ adc_bridge_1
U98 GND Net-_U102-Pad98_ adc_bridge_1
U77 GND Net-_U102-Pad77_ adc_bridge_1
U75 GND Net-_U102-Pad75_ adc_bridge_1
U78 GND Net-_U102-Pad78_ adc_bridge_1
U76 GND Net-_U102-Pad76_ adc_bridge_1
U74 GND Net-_U102-Pad74_ adc_bridge_1
U83 GND Net-_U102-Pad83_ adc_bridge_1
U82 GND Net-_U102-Pad82_ adc_bridge_1
U81 GND Net-_U102-Pad81_ adc_bridge_1
U80 GND Net-_U102-Pad80_ adc_bridge_1
U79 GND Net-_U102-Pad79_ adc_bridge_1
I2 Net-_I2-Pad1_ GND 5V
I3 Net-_I3-Pad1_ GND 5V
U207 apb_ready_in plot_v1
v5 apb_ready_in GND pulse
U65 GND Net-_U102-Pad65_ adc_bridge_1
U69 apb_ready_in Net-_U102-Pad69_ adc_bridge_1
U68 Net-_I3-Pad1_ Net-_U102-Pad68_ adc_bridge_1
U67 GND Net-_U102-Pad67_ adc_bridge_1
U66 GND Net-_U102-Pad66_ adc_bridge_1
U70 GND Net-_U102-Pad70_ adc_bridge_1
U73 GND Net-_U102-Pad73_ adc_bridge_1
U72 GND Net-_U102-Pad72_ adc_bridge_1
U71 GND Net-_U102-Pad71_ adc_bridge_1
U64 GND Net-_U102-Pad64_ adc_bridge_1
U61 GND Net-_U102-Pad61_ adc_bridge_1
U62 GND Net-_U102-Pad62_ adc_bridge_1
U63 GND Net-_U102-Pad63_ adc_bridge_1
U59 GND Net-_U102-Pad59_ adc_bridge_1
U58 GND Net-_U102-Pad58_ adc_bridge_1
U60 GND Net-_U102-Pad60_ adc_bridge_1
U167 Net-_U102-Pad166_ unconnected-_U167-Pad2_ dac_bridge_1
U168 Net-_U102-Pad167_ unconnected-_U168-Pad2_ dac_bridge_1
U169 Net-_U102-Pad168_ apb_wdata_out0 dac_bridge_1
U162 Net-_U102-Pad161_ unconnected-_U162-Pad2_ dac_bridge_1
U163 Net-_U102-Pad162_ unconnected-_U163-Pad2_ dac_bridge_1
U164 Net-_U102-Pad163_ unconnected-_U164-Pad2_ dac_bridge_1
U165 Net-_U102-Pad164_ unconnected-_U165-Pad2_ dac_bridge_1
U166 Net-_U102-Pad165_ unconnected-_U166-Pad2_ dac_bridge_1
U171 Net-_U102-Pad170_ unconnected-_U171-Pad2_ dac_bridge_1
U173 Net-_U102-Pad172_ unconnected-_U173-Pad2_ dac_bridge_1
U172 Net-_U102-Pad171_ unconnected-_U172-Pad2_ dac_bridge_1
U170 Net-_U102-Pad169_ unconnected-_U170-Pad2_ dac_bridge_1
U102 Net-_U1-Pad2_ Net-_U102-Pad2_ Net-_U102-Pad3_ Net-_U102-Pad4_ Net-_U102-Pad5_ Net-_U102-Pad6_ Net-_U102-Pad7_ Net-_U102-Pad8_ Net-_U102-Pad9_ Net-_U10-Pad2_ Net-_U102-Pad11_ Net-_U102-Pad12_ Net-_U102-Pad13_ Net-_U102-Pad14_ Net-_U102-Pad15_ Net-_U102-Pad16_ Net-_U102-Pad17_ Net-_U102-Pad18_ Net-_U102-Pad19_ Net-_U102-Pad20_ Net-_U102-Pad21_ Net-_U102-Pad22_ Net-_U102-Pad23_ Net-_U102-Pad24_ Net-_U102-Pad25_ Net-_U102-Pad26_ Net-_U102-Pad27_ Net-_U102-Pad28_ Net-_U102-Pad29_ Net-_U102-Pad30_ Net-_U102-Pad31_ Net-_U102-Pad32_ Net-_U102-Pad33_ Net-_U102-Pad34_ Net-_U102-Pad35_ Net-_U102-Pad36_ Net-_U102-Pad37_ Net-_U102-Pad38_ Net-_U102-Pad39_ Net-_U102-Pad40_ Net-_U102-Pad41_ Net-_U102-Pad42_ Net-_U102-Pad43_ Net-_U102-Pad44_ Net-_U102-Pad45_ Net-_U102-Pad46_ Net-_U102-Pad47_ Net-_U102-Pad48_ Net-_U102-Pad49_ Net-_U102-Pad50_ Net-_U102-Pad51_ Net-_U102-Pad52_ Net-_U102-Pad53_ Net-_U102-Pad54_ Net-_U102-Pad55_ Net-_U102-Pad56_ Net-_U102-Pad57_ Net-_U102-Pad58_ Net-_U102-Pad59_ Net-_U102-Pad60_ Net-_U102-Pad61_ Net-_U102-Pad62_ Net-_U102-Pad63_ Net-_U102-Pad64_ Net-_U102-Pad65_ Net-_U102-Pad66_ Net-_U102-Pad67_ Net-_U102-Pad68_ Net-_U102-Pad69_ Net-_U102-Pad70_ Net-_U102-Pad71_ Net-_U102-Pad72_ Net-_U102-Pad73_ Net-_U102-Pad74_ Net-_U102-Pad75_ Net-_U102-Pad76_ Net-_U102-Pad77_ Net-_U102-Pad78_ Net-_U102-Pad79_ Net-_U102-Pad80_ Net-_U102-Pad81_ Net-_U102-Pad82_ Net-_U102-Pad83_ Net-_U102-Pad84_ Net-_U102-Pad85_ Net-_U102-Pad86_ Net-_U102-Pad87_ Net-_U102-Pad88_ Net-_U102-Pad89_ Net-_U102-Pad90_ Net-_U102-Pad91_ Net-_U102-Pad92_ Net-_U102-Pad93_ Net-_U102-Pad94_ Net-_U102-Pad95_ Net-_U102-Pad96_ Net-_U102-Pad97_ Net-_U102-Pad98_ Net-_U102-Pad99_ Net-_U100-Pad2_ Net-_U101-Pad2_ Net-_U102-Pad102_ Net-_U102-Pad103_ Net-_U102-Pad104_ Net-_U102-Pad105_ Net-_U102-Pad106_ Net-_U102-Pad107_ Net-_U102-Pad108_ Net-_U102-Pad109_ Net-_U102-Pad110_ Net-_U102-Pad111_ Net-_U102-Pad112_ Net-_U102-Pad113_ Net-_U102-Pad114_ Net-_U102-Pad115_ Net-_U102-Pad116_ Net-_U102-Pad117_ Net-_U102-Pad118_ Net-_U102-Pad119_ Net-_U102-Pad120_ Net-_U102-Pad121_ Net-_U102-Pad122_ Net-_U102-Pad123_ Net-_U102-Pad124_ Net-_U102-Pad125_ Net-_U102-Pad126_ Net-_U102-Pad127_ Net-_U102-Pad128_ Net-_U102-Pad129_ Net-_U102-Pad130_ Net-_U102-Pad131_ Net-_U102-Pad132_ Net-_U102-Pad133_ Net-_U102-Pad134_ Net-_U102-Pad135_ Net-_U102-Pad136_ Net-_U102-Pad137_ Net-_U102-Pad138_ Net-_U102-Pad139_ Net-_U102-Pad140_ Net-_U102-Pad141_ Net-_U102-Pad142_ Net-_U102-Pad143_ Net-_U102-Pad144_ Net-_U102-Pad145_ Net-_U102-Pad146_ Net-_U102-Pad147_ Net-_U102-Pad148_ Net-_U102-Pad149_ Net-_U102-Pad150_ Net-_U102-Pad151_ Net-_U102-Pad152_ Net-_U102-Pad153_ Net-_U102-Pad154_ Net-_U102-Pad155_ Net-_U102-Pad156_ Net-_U102-Pad157_ Net-_U102-Pad158_ Net-_U102-Pad159_ Net-_U102-Pad160_ Net-_U102-Pad161_ Net-_U102-Pad162_ Net-_U102-Pad163_ Net-_U102-Pad164_ Net-_U102-Pad165_ Net-_U102-Pad166_ Net-_U102-Pad167_ Net-_U102-Pad168_ Net-_U102-Pad169_ Net-_U102-Pad170_ Net-_U102-Pad171_ Net-_U102-Pad172_ Net-_U102-Pad173_ Net-_U102-Pad174_ Net-_U102-Pad175_ Net-_U102-Pad176_ Net-_U102-Pad177_ Net-_U102-Pad178_ Net-_U102-Pad179_ Net-_U102-Pad180_ Net-_U102-Pad181_ Net-_U102-Pad182_ Net-_U102-Pad183_ Net-_U102-Pad184_ Net-_U102-Pad185_ Net-_U102-Pad186_ Net-_U102-Pad187_ Net-_U102-Pad188_ Net-_U102-Pad189_ Net-_U102-Pad190_ Net-_U102-Pad191_ Net-_U102-Pad192_ Net-_U102-Pad193_ Net-_U102-Pad194_ Net-_U102-Pad195_ Net-_U102-Pad196_ Net-_U102-Pad197_ Net-_U102-Pad198_ Net-_U102-Pad199_ Net-_U102-Pad200_ Net-_U102-Pad201_ amba_apb_bridge
U147 Net-_U102-Pad146_ unconnected-_U147-Pad2_ dac_bridge_1
U149 Net-_U102-Pad148_ unconnected-_U149-Pad2_ dac_bridge_1
U153 Net-_U102-Pad152_ unconnected-_U153-Pad2_ dac_bridge_1
U152 Net-_U102-Pad151_ unconnected-_U152-Pad2_ dac_bridge_1
U150 Net-_U102-Pad149_ unconnected-_U150-Pad2_ dac_bridge_1
U151 Net-_U102-Pad150_ unconnected-_U151-Pad2_ dac_bridge_1
U148 Net-_U102-Pad147_ unconnected-_U148-Pad2_ dac_bridge_1
U154 Net-_U102-Pad153_ unconnected-_U154-Pad2_ dac_bridge_1
U155 Net-_U102-Pad154_ unconnected-_U155-Pad2_ dac_bridge_1
U156 Net-_U102-Pad155_ unconnected-_U156-Pad2_ dac_bridge_1
U161 Net-_U102-Pad160_ unconnected-_U161-Pad2_ dac_bridge_1
U160 Net-_U102-Pad159_ unconnected-_U160-Pad2_ dac_bridge_1
U157 Net-_U102-Pad156_ unconnected-_U157-Pad2_ dac_bridge_1
U158 Net-_U102-Pad157_ unconnected-_U158-Pad2_ dac_bridge_1
U159 Net-_U102-Pad158_ unconnected-_U159-Pad2_ dac_bridge_1
U145 Net-_U102-Pad144_ unconnected-_U145-Pad2_ dac_bridge_1
U146 Net-_U102-Pad145_ unconnected-_U146-Pad2_ dac_bridge_1
U144 Net-_U102-Pad143_ unconnected-_U144-Pad2_ dac_bridge_1
U142 Net-_U102-Pad141_ unconnected-_U142-Pad2_ dac_bridge_1
U143 Net-_U102-Pad142_ unconnected-_U143-Pad2_ dac_bridge_1
U139 Net-_U102-Pad138_ unconnected-_U139-Pad2_ dac_bridge_1
U140 Net-_U102-Pad139_ unconnected-_U140-Pad2_ dac_bridge_1
U137 Net-_U102-Pad136_ apb_addr_out0 dac_bridge_1
U141 Net-_U102-Pad140_ unconnected-_U141-Pad2_ dac_bridge_1
U138 Net-_U102-Pad137_ unconnected-_U138-Pad2_ dac_bridge_1
U209 apb_addr_out0 plot_v1
U110 Net-_U102-Pad109_ unconnected-_U110-Pad2_ dac_bridge_1
U115 Net-_U102-Pad114_ unconnected-_U115-Pad2_ dac_bridge_1
U111 Net-_U102-Pad110_ unconnected-_U111-Pad2_ dac_bridge_1
U112 Net-_U102-Pad111_ unconnected-_U112-Pad2_ dac_bridge_1
U113 Net-_U102-Pad112_ unconnected-_U113-Pad2_ dac_bridge_1
U114 Net-_U102-Pad113_ unconnected-_U114-Pad2_ dac_bridge_1
U116 Net-_U102-Pad115_ unconnected-_U116-Pad2_ dac_bridge_1
U129 Net-_U102-Pad128_ unconnected-_U129-Pad2_ dac_bridge_1
U124 Net-_U102-Pad123_ unconnected-_U124-Pad2_ dac_bridge_1
U127 Net-_U102-Pad126_ unconnected-_U127-Pad2_ dac_bridge_1
U126 Net-_U102-Pad125_ unconnected-_U126-Pad2_ dac_bridge_1
U128 Net-_U102-Pad127_ unconnected-_U128-Pad2_ dac_bridge_1
U125 Net-_U102-Pad124_ unconnected-_U125-Pad2_ dac_bridge_1
U130 Net-_U102-Pad129_ unconnected-_U130-Pad2_ dac_bridge_1
U123 Net-_U102-Pad122_ unconnected-_U123-Pad2_ dac_bridge_1
U122 Net-_U102-Pad121_ unconnected-_U122-Pad2_ dac_bridge_1
U119 Net-_U102-Pad118_ unconnected-_U119-Pad2_ dac_bridge_1
U121 Net-_U102-Pad120_ unconnected-_U121-Pad2_ dac_bridge_1
U117 Net-_U102-Pad116_ unconnected-_U117-Pad2_ dac_bridge_1
U120 Net-_U102-Pad119_ unconnected-_U120-Pad2_ dac_bridge_1
U118 Net-_U102-Pad117_ unconnected-_U118-Pad2_ dac_bridge_1
U136 Net-_U102-Pad135_ unconnected-_U136-Pad2_ dac_bridge_1
U135 Net-_U102-Pad134_ unconnected-_U135-Pad2_ dac_bridge_1
U131 Net-_U102-Pad130_ unconnected-_U131-Pad2_ dac_bridge_1
U132 Net-_U102-Pad131_ unconnected-_U132-Pad2_ dac_bridge_1
U134 Net-_U102-Pad133_ unconnected-_U134-Pad2_ dac_bridge_1
U133 Net-_U102-Pad132_ unconnected-_U133-Pad2_ dac_bridge_1
U107 Net-_U102-Pad106_ unconnected-_U107-Pad2_ dac_bridge_1
U108 Net-_U102-Pad107_ unconnected-_U108-Pad2_ dac_bridge_1
U106 Net-_U102-Pad105_ unconnected-_U106-Pad2_ dac_bridge_1
U105 Net-_U102-Pad104_ apb_write_out dac_bridge_1
U104 Net-_U102-Pad103_ apb_enable_out dac_bridge_1
U109 Net-_U102-Pad108_ unconnected-_U109-Pad2_ dac_bridge_1
U103 Net-_U102-Pad102_ apb_sel_out dac_bridge_1
U214 apb_write_out plot_v1
U213 apb_enable_out plot_v1
U212 apb_sel_out plot_v1
U188 Net-_U102-Pad187_ unconnected-_U188-Pad2_ dac_bridge_1
U189 Net-_U102-Pad188_ unconnected-_U189-Pad2_ dac_bridge_1
U187 Net-_U102-Pad186_ unconnected-_U187-Pad2_ dac_bridge_1
U190 Net-_U102-Pad189_ unconnected-_U190-Pad2_ dac_bridge_1
U186 Net-_U102-Pad185_ unconnected-_U186-Pad2_ dac_bridge_1
U191 Net-_U102-Pad190_ unconnected-_U191-Pad2_ dac_bridge_1
U192 Net-_U102-Pad191_ unconnected-_U192-Pad2_ dac_bridge_1
U182 Net-_U102-Pad181_ unconnected-_U182-Pad2_ dac_bridge_1
U185 Net-_U102-Pad184_ unconnected-_U185-Pad2_ dac_bridge_1
U184 Net-_U102-Pad183_ unconnected-_U184-Pad2_ dac_bridge_1
U183 Net-_U102-Pad182_ unconnected-_U183-Pad2_ dac_bridge_1
U181 Net-_U102-Pad180_ unconnected-_U181-Pad2_ dac_bridge_1
U180 Net-_U102-Pad179_ unconnected-_U180-Pad2_ dac_bridge_1
U179 Net-_U102-Pad178_ unconnected-_U179-Pad2_ dac_bridge_1
U211 sys_trans_done plot_v1
U210 sys_rdata_out0 plot_v1
U201 Net-_U102-Pad200_ sys_rdata_out0 dac_bridge_1
U202 Net-_U102-Pad201_ sys_trans_done dac_bridge_1
U198 Net-_U102-Pad197_ unconnected-_U198-Pad2_ dac_bridge_1
U200 Net-_U102-Pad199_ unconnected-_U200-Pad2_ dac_bridge_1
U199 Net-_U102-Pad198_ unconnected-_U199-Pad2_ dac_bridge_1
U197 Net-_U102-Pad196_ unconnected-_U197-Pad2_ dac_bridge_1
U196 Net-_U102-Pad195_ unconnected-_U196-Pad2_ dac_bridge_1
U194 Net-_U102-Pad193_ unconnected-_U194-Pad2_ dac_bridge_1
U193 Net-_U102-Pad192_ unconnected-_U193-Pad2_ dac_bridge_1
U195 Net-_U102-Pad194_ unconnected-_U195-Pad2_ dac_bridge_1
U177 Net-_U102-Pad176_ unconnected-_U177-Pad2_ dac_bridge_1
U174 Net-_U102-Pad173_ unconnected-_U174-Pad2_ dac_bridge_1
U175 Net-_U102-Pad174_ unconnected-_U175-Pad2_ dac_bridge_1
U176 Net-_U102-Pad175_ unconnected-_U176-Pad2_ dac_bridge_1
U178 Net-_U102-Pad177_ unconnected-_U178-Pad2_ dac_bridge_1
U208 apb_wdata_out0 plot_v1
I1 Net-_I1-Pad1_ GND  5V
U29 GND Net-_U102-Pad29_ adc_bridge_1
U32 GND Net-_U102-Pad32_ adc_bridge_1
U31 GND Net-_U102-Pad31_ adc_bridge_1
U30 GND Net-_U102-Pad30_ adc_bridge_1
U28 GND Net-_U102-Pad28_ adc_bridge_1
U33 GND Net-_U102-Pad33_ adc_bridge_1
U41 GND Net-_U102-Pad41_ adc_bridge_1
U40 GND Net-_U102-Pad40_ adc_bridge_1
U43 GND Net-_U102-Pad43_ adc_bridge_1
U44 GND Net-_U102-Pad44_ adc_bridge_1
U39 GND Net-_U102-Pad39_ adc_bridge_1
U42 GND Net-_U102-Pad42_ adc_bridge_1
U37 GND Net-_U102-Pad37_ adc_bridge_1
U36 Net-_I1-Pad1_ Net-_U102-Pad36_ adc_bridge_1
U34 GND Net-_U102-Pad34_ adc_bridge_1
U35 GND Net-_U102-Pad35_ adc_bridge_1
U38 GND Net-_U102-Pad38_ adc_bridge_1
U25 GND Net-_U102-Pad25_ adc_bridge_1
U27 GND Net-_U102-Pad27_ adc_bridge_1
U24 GND Net-_U102-Pad24_ adc_bridge_1
U23 GND Net-_U102-Pad23_ adc_bridge_1
U26 GND Net-_U102-Pad26_ adc_bridge_1
U56 GND Net-_U102-Pad56_ adc_bridge_1
U52 GND Net-_U102-Pad52_ adc_bridge_1
U54 GND Net-_U102-Pad54_ adc_bridge_1
U53 GND Net-_U102-Pad53_ adc_bridge_1
U55 GND Net-_U102-Pad55_ adc_bridge_1
U51 GND Net-_U102-Pad51_ adc_bridge_1
U57 GND Net-_U102-Pad57_ adc_bridge_1
U45 GND Net-_U102-Pad45_ adc_bridge_1
U46 GND Net-_U102-Pad46_ adc_bridge_1
U50 GND Net-_U102-Pad50_ adc_bridge_1
U49 GND Net-_U102-Pad49_ adc_bridge_1
U48 GND Net-_U102-Pad48_ adc_bridge_1
U47 GND Net-_U102-Pad47_ adc_bridge_1
.end
